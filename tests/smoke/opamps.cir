* Operating-point smoke test for all operational-amplifier models
.include spice/OpAmps.lib

V_POS VPOS 0 15
V_NEG VNEG 0 -15
V_5V V5 0 5

V_UA_IN UA_IN 0 0
X_UA UA_OFFSET1 UA_OUT UA_IN VNEG UA_OFFSET2 UA_OUT VPOS UA741CP
R_UA_LOAD UA_OUT 0 10k

V_TL_IN1 TL_IN1 0 1
V_TL_IN2 TL_IN2 0 -1
X_TL TL_OUT1 TL_OUT1 TL_IN1 VNEG TL_IN2 TL_OUT2 TL_OUT2 VPOS TL072CP
R_TL_LOAD1 TL_OUT1 0 10k
R_TL_LOAD2 TL_OUT2 0 10k

V_LM_IN1 LM_IN1 0 1
V_LM_IN2 LM_IN2 0 2
X_LM LM_OUT1 LM_OUT1 LM_IN1 0 LM_IN2 LM_OUT2 LM_OUT2 V5 LM358P
R_LM_LOAD1 LM_OUT1 0 10k
R_LM_LOAD2 LM_OUT2 0 10k

.op
.end
