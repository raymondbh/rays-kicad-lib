* Syntax and operating-point smoke test for every public model
.include spice/BJT_NPN.lib
.include spice/BJT_PNP.lib
.include spice/Diodes.lib
.include spice/Passives.lib

VCC VCC 0 5
VBN BN 0 0.75
R_N1 VCC NC1 1k
R_N2 VCC NC2 1k
R_N3 VCC NC3 1k
R_N4 VCC NC4 1k
R_N5 VCC NC5 1k
R_N6 VCC NC6 1k
R_N7 VCC NC7 1k
Q_N1 NC1 BN 0 BD139
Q_N2 NC2 BN 0 BD175
Q_N3 NC3 BN 0 2N3904
Q_N4 NC4 BN 0 2N5551
Q_N5 NC5 BN 0 BC847A
Q_N6 NC6 BN 0 BC847B
Q_N7 NC7 BN 0 BC847C

VBP BP 0 4.25
R_P1 PC1 0 1k
R_P2 PC2 0 1k
R_P3 PC3 0 1k
R_P4 PC4 0 1k
R_P5 PC5 0 1k
R_P6 PC6 0 1k
R_P7 PC7 0 1k
Q_P1 PC1 BP VCC BD140
Q_P2 PC2 BP VCC BD176
Q_P3 PC3 BP VCC 2N3906
Q_P4 PC4 BP VCC 2N5401
Q_P5 PC5 BP VCC BC857A
Q_P6 PC6 BP VCC BC857B
Q_P7 PC7 BP VCC BC857C

VDF DF 0 5
R_D1 DF DA1 330
R_D2 DF DA2 330
R_D3 DF DA3 330
R_D4 DF DA4 330
R_D5 DF DA5 330
D_D1 DA1 0 1N5817
D_D2 DA2 0 1N5818
D_D3 DA3 0 1N5819
D_D4 DA4 0 PDZ12B
X_D5 DA5 0 1N4148

R_LED1 DF LA1 330
R_LED2 DF LA2 330
R_LED3 DF LA3 330
R_LED4 DF LA4 330
X_LED1 LA1 0 LED_RED
X_LED2 LA2 0 LED_GREEN
X_LED3 LA3 0 LED_BLUE
X_LED4 LA4 0 LED_WHITE

R_R1 DF RA1 330
R_R2 DF RA2 330
R_R3 DF RA3 330
R_R4 DF RA4 330
R_R5 DF RA5 330
R_R6 DF RA6 330
R_R7 DF RA7 330
X_R1 RA1 0 1N4001
X_R2 RA2 0 1N4002
X_R3 RA3 0 1N4003
X_R4 RA4 0 1N4004
X_R5 RA5 0 1N4005
X_R6 RA6 0 1N4006
X_R7 RA7 0 1N4007

VZ ZSUP 0 100
R_Z1 ZSUP ZK1 10k
R_Z2 ZSUP ZK2 10k
R_Z3 ZSUP ZK3 10k
R_Z4 ZSUP ZK4 10k
R_Z5 ZSUP ZK5 10k
R_Z6 ZSUP ZK6 10k
R_Z7 ZSUP ZK7 10k
I_Z8 0 ZK8 5m
I_Z9 0 ZK9 21m
X_Z1 0 ZK1 BZX55C2V7
X_Z2 0 ZK2 BZX55C3V6
X_Z3 0 ZK3 BZX55C5V1
X_Z4 0 ZK4 BZX55C6V2
X_Z5 0 ZK5 BZX55C18
X_Z6 0 ZK6 BZX55C30
X_Z7 0 ZK7 BZX55C68
X_Z8 0 ZK8 BZX55C10
X_Z9 0 ZK9 1N4742A

VPA PA 0 5
X_POT PA PW 0 POTLIN PARAMS: R=10k POS=0.5 RW=0.1
R_LOAD PW 0 10k

.op
.end
